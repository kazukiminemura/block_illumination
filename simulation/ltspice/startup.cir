Rev B buffer enable / USB absent / reset functional test
.param FLOOD=0 CASE=0
.step param CASE list 0 1 2 3 4
.include full_models.lib
VDD VCC 0 5
VEN EN 0 PWL(0 {if(CASE<2,0,3.3)} 500u {if(CASE<2,0,3.3)} 500.01u {if(CASE==4,0,if(CASE<2,0,3.3))})
VIN A 0 {if(CASE==1,3.3,if(CASE==2,3.3,0))}
REN EN BASE 4.7k
RPD BASE 0 100k
QEN OE BASE 0 EN_NPN
ROE VCC OE 10k
XBUF OE A BR OE A BG 0 NC3 0 OE NC4 0 OE VCC AHCT125_FUNC
RBR VCC BR 10k
RBG VCC BG 10k
.tran 0 1m 0 100n
.meas tran BLANK_R_END FIND V(BR) AT=900u
.meas tran BLANK_G_END FIND V(BG) AT=900u
.meas tran OE_END FIND V(OE) AT=900u
.end
