3-channel PWM filter and high-impedance Pico reset test
VDD VIN 0 5
RFEED VIN 5V 0.1
CBULK 5V 0 100u Rser=0.1
VPWM_CPU DRIVE_CPU 0 PULSE(0 {VGPIO} 100m 20n 20n {DT0*50u} 50u)
SIO_CPU DRIVE_CPU PWM_CPU EN 0 GPIO_SW
RPD_CPU PWM_CPU 0 10k
RF_CPU PWM_CPU SIG_CPU {4700*RFAC}
CF_CPU SIG_CPU 0 {CFVAL}
XU_CPU K_CPU_1_SINK 0 VCC_CPU 0 SIG_CPU REF_CPU REF_CPU 0 5V K_CPU_10_SINK K_CPU_9_SINK K_CPU_8_SINK K_CPU_7_SINK K_CPU_6_SINK K_CPU_5_SINK K_CPU_4_SINK K_CPU_3_SINK K_CPU_2_SINK XD3914 VREFVAL={VR0} RLAD={RLADVAL} ERR={THERR} ISCALE={ISCALE}
VLOGIC_CPU 5V VCC_CPU 0
RSET_CPU REF_CPU 0 {3300*RSETFAC}
CD_CPU 5V 0 100n
CB_CPU 5V 0 10u Rser=0.1
XLED_CPU 5V 5V 5V 5V 5V 5V 5V 5V 5V 5V K_CPU_10 K_CPU_9 K_CPU_8 K_CPU_7 K_CPU_6 K_CPU_5 K_CPU_4 K_CPU_3 K_CPU_2 K_CPU_1 OSX10201_GYR1
VS_CPU_1 K_CPU_1 K_CPU_1_SINK 0
VS_CPU_2 K_CPU_2 K_CPU_2_SINK 0
VS_CPU_3 K_CPU_3 K_CPU_3_SINK 0
VS_CPU_4 K_CPU_4 K_CPU_4_SINK 0
VS_CPU_5 K_CPU_5 K_CPU_5_SINK 0
VS_CPU_6 K_CPU_6 K_CPU_6_SINK 0
VS_CPU_7 K_CPU_7 K_CPU_7_SINK 0
VS_CPU_8 K_CPU_8 K_CPU_8_SINK 0
VS_CPU_9 K_CPU_9 K_CPU_9_SINK 0
VS_CPU_10 K_CPU_10 K_CPU_10_SINK 0
VPWM_GPU DRIVE_GPU 0 PULSE(0 {VGPIO} 100m 20n 20n {DT1*50u} 50u)
SIO_GPU DRIVE_GPU PWM_GPU EN 0 GPIO_SW
RPD_GPU PWM_GPU 0 10k
RF_GPU PWM_GPU SIG_GPU {4700*RFAC}
CF_GPU SIG_GPU 0 {CFVAL}
XU_GPU K_GPU_1_SINK 0 VCC_GPU 0 SIG_GPU REF_GPU REF_GPU 0 5V K_GPU_10_SINK K_GPU_9_SINK K_GPU_8_SINK K_GPU_7_SINK K_GPU_6_SINK K_GPU_5_SINK K_GPU_4_SINK K_GPU_3_SINK K_GPU_2_SINK XD3914 VREFVAL={VR1} RLAD={RLADVAL} ERR={THERR} ISCALE={ISCALE}
VLOGIC_GPU 5V VCC_GPU 0
RSET_GPU REF_GPU 0 {3300*RSETFAC}
CD_GPU 5V 0 100n
CB_GPU 5V 0 10u Rser=0.1
XLED_GPU 5V 5V 5V 5V 5V 5V 5V 5V 5V 5V K_GPU_10 K_GPU_9 K_GPU_8 K_GPU_7 K_GPU_6 K_GPU_5 K_GPU_4 K_GPU_3 K_GPU_2 K_GPU_1 OSX10201_GYR1
VS_GPU_1 K_GPU_1 K_GPU_1_SINK 0
VS_GPU_2 K_GPU_2 K_GPU_2_SINK 0
VS_GPU_3 K_GPU_3 K_GPU_3_SINK 0
VS_GPU_4 K_GPU_4 K_GPU_4_SINK 0
VS_GPU_5 K_GPU_5 K_GPU_5_SINK 0
VS_GPU_6 K_GPU_6 K_GPU_6_SINK 0
VS_GPU_7 K_GPU_7 K_GPU_7_SINK 0
VS_GPU_8 K_GPU_8 K_GPU_8_SINK 0
VS_GPU_9 K_GPU_9 K_GPU_9_SINK 0
VS_GPU_10 K_GPU_10 K_GPU_10_SINK 0
VPWM_NPU DRIVE_NPU 0 PULSE(0 {VGPIO} 100m 20n 20n {DT2*50u} 50u)
SIO_NPU DRIVE_NPU PWM_NPU EN 0 GPIO_SW
RPD_NPU PWM_NPU 0 10k
RF_NPU PWM_NPU SIG_NPU {4700*RFAC}
CF_NPU SIG_NPU 0 {CFVAL}
XU_NPU K_NPU_1_SINK 0 VCC_NPU 0 SIG_NPU REF_NPU REF_NPU 0 5V K_NPU_10_SINK K_NPU_9_SINK K_NPU_8_SINK K_NPU_7_SINK K_NPU_6_SINK K_NPU_5_SINK K_NPU_4_SINK K_NPU_3_SINK K_NPU_2_SINK XD3914 VREFVAL={VR2} RLAD={RLADVAL} ERR={THERR} ISCALE={ISCALE}
VLOGIC_NPU 5V VCC_NPU 0
RSET_NPU REF_NPU 0 {3300*RSETFAC}
CD_NPU 5V 0 100n
CB_NPU 5V 0 10u Rser=0.1
XLED_NPU 5V 5V 5V 5V 5V 5V 5V 5V 5V 5V K_NPU_10 K_NPU_9 K_NPU_8 K_NPU_7 K_NPU_6 K_NPU_5 K_NPU_4 K_NPU_3 K_NPU_2 K_NPU_1 OSX10201_GYR1
VS_NPU_1 K_NPU_1 K_NPU_1_SINK 0
VS_NPU_2 K_NPU_2 K_NPU_2_SINK 0
VS_NPU_3 K_NPU_3 K_NPU_3_SINK 0
VS_NPU_4 K_NPU_4 K_NPU_4_SINK 0
VS_NPU_5 K_NPU_5 K_NPU_5_SINK 0
VS_NPU_6 K_NPU_6 K_NPU_6_SINK 0
VS_NPU_7 K_NPU_7 K_NPU_7_SINK 0
VS_NPU_8 K_NPU_8 K_NPU_8_SINK 0
VS_NPU_9 K_NPU_9 K_NPU_9_SINK 0
VS_NPU_10 K_NPU_10 K_NPU_10_SINK 0
VEN EN 0 PWL(0 1 399.999m 1 400m 0)
.include meter_models.lib
.param VR0=1.28 VR1=1.28 VR2=1.28 VGPIO=3.3 RFAC=1 CFVAL=4.7u RSETFAC=1 RLADVAL=12k THERR=0 ISCALE=1
.param DT0={(3.5/10)*VR0/VGPIO} DT1={(6.5/10)*VR1/VGPIO} DT2={1.08*VR2/VGPIO}
.options plotwinsize=0
.save V(5V) V(EN) V(SIG_CPU) V(REF_CPU) V(VCC_CPU) I(VLOGIC_CPU) V(SIG_GPU) V(REF_GPU) V(VCC_GPU) I(VLOGIC_GPU) V(SIG_NPU) V(REF_NPU) V(VCC_NPU) I(VLOGIC_NPU) I(VS_CPU_1) V(K_CPU_1_SINK) I(VS_CPU_2) V(K_CPU_2_SINK) I(VS_CPU_3) V(K_CPU_3_SINK) I(VS_CPU_4) V(K_CPU_4_SINK) I(VS_CPU_5) V(K_CPU_5_SINK) I(VS_CPU_6) V(K_CPU_6_SINK) I(VS_CPU_7) V(K_CPU_7_SINK) I(VS_CPU_8) V(K_CPU_8_SINK) I(VS_CPU_9) V(K_CPU_9_SINK) I(VS_CPU_10) V(K_CPU_10_SINK) I(VS_GPU_1) V(K_GPU_1_SINK) I(VS_GPU_2) V(K_GPU_2_SINK) I(VS_GPU_3) V(K_GPU_3_SINK) I(VS_GPU_4) V(K_GPU_4_SINK) I(VS_GPU_5) V(K_GPU_5_SINK) I(VS_GPU_6) V(K_GPU_6_SINK) I(VS_GPU_7) V(K_GPU_7_SINK) I(VS_GPU_8) V(K_GPU_8_SINK) I(VS_GPU_9) V(K_GPU_9_SINK) I(VS_GPU_10) V(K_GPU_10_SINK) I(VS_NPU_1) V(K_NPU_1_SINK) I(VS_NPU_2) V(K_NPU_2_SINK) I(VS_NPU_3) V(K_NPU_3_SINK) I(VS_NPU_4) V(K_NPU_4_SINK) I(VS_NPU_5) V(K_NPU_5_SINK) I(VS_NPU_6) V(K_NPU_6_SINK) I(VS_NPU_7) V(K_NPU_7_SINK) I(VS_NPU_8) V(K_NPU_8_SINK) I(VS_NPU_9) V(K_NPU_9_SINK) I(VS_NPU_10) V(K_NPU_10_SINK) I(VDD)
.step param CFVAL list 2.2u 6.8u
.tran 0 800m 0 2u
.meas tran CPU_SIG AVG V(SIG_CPU) FROM 330m TO 350m
.meas tran CPU_RIPPLE PP V(SIG_CPU) FROM 330m TO 350m
.meas tran CPU_COUNT FIND (if(I(VS_CPU_1)>1m,1,0)+if(I(VS_CPU_2)>1m,1,0)+if(I(VS_CPU_3)>1m,1,0)+if(I(VS_CPU_4)>1m,1,0)+if(I(VS_CPU_5)>1m,1,0)+if(I(VS_CPU_6)>1m,1,0)+if(I(VS_CPU_7)>1m,1,0)+if(I(VS_CPU_8)>1m,1,0)+if(I(VS_CPU_9)>1m,1,0)+if(I(VS_CPU_10)>1m,1,0)) AT=350m
.meas tran CPU_RESET FIND (if(I(VS_CPU_1)>1m,1,0)+if(I(VS_CPU_2)>1m,1,0)+if(I(VS_CPU_3)>1m,1,0)+if(I(VS_CPU_4)>1m,1,0)+if(I(VS_CPU_5)>1m,1,0)+if(I(VS_CPU_6)>1m,1,0)+if(I(VS_CPU_7)>1m,1,0)+if(I(VS_CPU_8)>1m,1,0)+if(I(VS_CPU_9)>1m,1,0)+if(I(VS_CPU_10)>1m,1,0)) AT=750m
.meas tran CPU_I AVG I(VS_CPU_1) FROM 330m TO 350m
.meas tran CPU_P AVG (V(K_CPU_1_SINK)*I(VS_CPU_1)+V(K_CPU_2_SINK)*I(VS_CPU_2)+V(K_CPU_3_SINK)*I(VS_CPU_3)+V(K_CPU_4_SINK)*I(VS_CPU_4)+V(K_CPU_5_SINK)*I(VS_CPU_5)+V(K_CPU_6_SINK)*I(VS_CPU_6)+V(K_CPU_7_SINK)*I(VS_CPU_7)+V(K_CPU_8_SINK)*I(VS_CPU_8)+V(K_CPU_9_SINK)*I(VS_CPU_9)+V(K_CPU_10_SINK)*I(VS_CPU_10)+V(VCC_CPU)*I(VLOGIC_CPU)) FROM 330m TO 350m
.meas tran CPU_START FIND (if(I(VS_CPU_1)>1m,1,0)+if(I(VS_CPU_2)>1m,1,0)+if(I(VS_CPU_3)>1m,1,0)+if(I(VS_CPU_4)>1m,1,0)+if(I(VS_CPU_5)>1m,1,0)+if(I(VS_CPU_6)>1m,1,0)+if(I(VS_CPU_7)>1m,1,0)+if(I(VS_CPU_8)>1m,1,0)+if(I(VS_CPU_9)>1m,1,0)+if(I(VS_CPU_10)>1m,1,0)) AT=50m
.meas tran GPU_SIG AVG V(SIG_GPU) FROM 330m TO 350m
.meas tran GPU_RIPPLE PP V(SIG_GPU) FROM 330m TO 350m
.meas tran GPU_COUNT FIND (if(I(VS_GPU_1)>1m,1,0)+if(I(VS_GPU_2)>1m,1,0)+if(I(VS_GPU_3)>1m,1,0)+if(I(VS_GPU_4)>1m,1,0)+if(I(VS_GPU_5)>1m,1,0)+if(I(VS_GPU_6)>1m,1,0)+if(I(VS_GPU_7)>1m,1,0)+if(I(VS_GPU_8)>1m,1,0)+if(I(VS_GPU_9)>1m,1,0)+if(I(VS_GPU_10)>1m,1,0)) AT=350m
.meas tran GPU_RESET FIND (if(I(VS_GPU_1)>1m,1,0)+if(I(VS_GPU_2)>1m,1,0)+if(I(VS_GPU_3)>1m,1,0)+if(I(VS_GPU_4)>1m,1,0)+if(I(VS_GPU_5)>1m,1,0)+if(I(VS_GPU_6)>1m,1,0)+if(I(VS_GPU_7)>1m,1,0)+if(I(VS_GPU_8)>1m,1,0)+if(I(VS_GPU_9)>1m,1,0)+if(I(VS_GPU_10)>1m,1,0)) AT=750m
.meas tran GPU_I AVG I(VS_GPU_1) FROM 330m TO 350m
.meas tran GPU_P AVG (V(K_GPU_1_SINK)*I(VS_GPU_1)+V(K_GPU_2_SINK)*I(VS_GPU_2)+V(K_GPU_3_SINK)*I(VS_GPU_3)+V(K_GPU_4_SINK)*I(VS_GPU_4)+V(K_GPU_5_SINK)*I(VS_GPU_5)+V(K_GPU_6_SINK)*I(VS_GPU_6)+V(K_GPU_7_SINK)*I(VS_GPU_7)+V(K_GPU_8_SINK)*I(VS_GPU_8)+V(K_GPU_9_SINK)*I(VS_GPU_9)+V(K_GPU_10_SINK)*I(VS_GPU_10)+V(VCC_GPU)*I(VLOGIC_GPU)) FROM 330m TO 350m
.meas tran GPU_START FIND (if(I(VS_GPU_1)>1m,1,0)+if(I(VS_GPU_2)>1m,1,0)+if(I(VS_GPU_3)>1m,1,0)+if(I(VS_GPU_4)>1m,1,0)+if(I(VS_GPU_5)>1m,1,0)+if(I(VS_GPU_6)>1m,1,0)+if(I(VS_GPU_7)>1m,1,0)+if(I(VS_GPU_8)>1m,1,0)+if(I(VS_GPU_9)>1m,1,0)+if(I(VS_GPU_10)>1m,1,0)) AT=50m
.meas tran NPU_SIG AVG V(SIG_NPU) FROM 330m TO 350m
.meas tran NPU_RIPPLE PP V(SIG_NPU) FROM 330m TO 350m
.meas tran NPU_COUNT FIND (if(I(VS_NPU_1)>1m,1,0)+if(I(VS_NPU_2)>1m,1,0)+if(I(VS_NPU_3)>1m,1,0)+if(I(VS_NPU_4)>1m,1,0)+if(I(VS_NPU_5)>1m,1,0)+if(I(VS_NPU_6)>1m,1,0)+if(I(VS_NPU_7)>1m,1,0)+if(I(VS_NPU_8)>1m,1,0)+if(I(VS_NPU_9)>1m,1,0)+if(I(VS_NPU_10)>1m,1,0)) AT=350m
.meas tran NPU_RESET FIND (if(I(VS_NPU_1)>1m,1,0)+if(I(VS_NPU_2)>1m,1,0)+if(I(VS_NPU_3)>1m,1,0)+if(I(VS_NPU_4)>1m,1,0)+if(I(VS_NPU_5)>1m,1,0)+if(I(VS_NPU_6)>1m,1,0)+if(I(VS_NPU_7)>1m,1,0)+if(I(VS_NPU_8)>1m,1,0)+if(I(VS_NPU_9)>1m,1,0)+if(I(VS_NPU_10)>1m,1,0)) AT=750m
.meas tran NPU_I AVG I(VS_NPU_1) FROM 330m TO 350m
.meas tran NPU_P AVG (V(K_NPU_1_SINK)*I(VS_NPU_1)+V(K_NPU_2_SINK)*I(VS_NPU_2)+V(K_NPU_3_SINK)*I(VS_NPU_3)+V(K_NPU_4_SINK)*I(VS_NPU_4)+V(K_NPU_5_SINK)*I(VS_NPU_5)+V(K_NPU_6_SINK)*I(VS_NPU_6)+V(K_NPU_7_SINK)*I(VS_NPU_7)+V(K_NPU_8_SINK)*I(VS_NPU_8)+V(K_NPU_9_SINK)*I(VS_NPU_9)+V(K_NPU_10_SINK)*I(VS_NPU_10)+V(VCC_NPU)*I(VLOGIC_NPU)) FROM 330m TO 350m
.meas tran NPU_START FIND (if(I(VS_NPU_1)>1m,1,0)+if(I(VS_NPU_2)>1m,1,0)+if(I(VS_NPU_3)>1m,1,0)+if(I(VS_NPU_4)>1m,1,0)+if(I(VS_NPU_5)>1m,1,0)+if(I(VS_NPU_6)>1m,1,0)+if(I(VS_NPU_7)>1m,1,0)+if(I(VS_NPU_8)>1m,1,0)+if(I(VS_NPU_9)>1m,1,0)+if(I(VS_NPU_10)>1m,1,0)) AT=50m
.meas tran SUPPLY_MIN MIN V(5V) FROM 0 TO 800m
.end
