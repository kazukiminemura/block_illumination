Full 3-panel LED circuit, functional serial models and assumed analog models
XPICO DATA_R_3V3 SCLK_R_3V3 LAT_R_3V3 BLANK_R_3V3 DATA_G_3V3 SCLK_G_3V3 LAT_G_3V3 BLANK_G_3V3 3V3 0 PICO_STIM
XBUF1 0 DATA_R_3V3 DATA_R 0 SCLK_R_3V3 SCLK_R 0 LAT_R LAT_R_3V3 0 BLANK_R BLANK_R_3V3 0 5V AHCT125_FUNC
RP0 DATA_R_3V3 0 10k
RP1 SCLK_R_3V3 0 10k
RP2 LAT_R_3V3 0 10k
RP3 BLANK_R_3V3 3V3 10k
XBUF2 0 DATA_G_3V3 DATA_G 0 SCLK_G_3V3 SCLK_G 0 LAT_G LAT_G_3V3 0 BLANK_G BLANK_G_3V3 0 5V AHCT125_FUNC
RP4 DATA_G_3V3 0 10k
RP5 SCLK_G_3V3 0 10k
RP6 LAT_G_3V3 0 10k
RP7 BLANK_G_3V3 3V3 10k
XR1 0 DATA_R SCLK_R LAT_R K_R_0 K_R_1 K_R_2 K_R_3 K_R_4 K_R_5 K_R_6 K_R_7 K_R_8 K_R_9 K_R_10 K_R_11 K_R_12 K_R_13 K_R_14 K_R_15 BLANK_R R_SER_1 R1_IREF 5V TLC5928_FUNC
RI_R1 R1_IREF 0 3.3k
XLED1 A_ROW_0 A_ROW_1 A_ROW_2 A_ROW_3 A_ROW_4 A_ROW_5 A_ROW_6 A_ROW_7 A_ROW_8 A_ROW_9 A_ROW_10 A_ROW_11 A_ROW_12 A_ROW_13 A_ROW_14 A_ROW_15 K_R_0 K_R_1 K_R_2 K_R_3 K_R_4 K_R_5 K_R_6 K_R_7 K_R_8 K_R_9 K_R_10 K_R_11 K_R_12 K_R_13 K_R_14 K_R_15 K_G_0 K_G_1 K_G_2 K_G_3 K_G_4 K_G_5 K_G_6 K_G_7 K_G_8 K_G_9 K_G_10 K_G_11 K_G_12 K_G_13 K_G_14 K_G_15 MATRIX16X16_RG
XR2 0 R_SER_1 SCLK_R LAT_R K_R_16 K_R_17 K_R_18 K_R_19 K_R_20 K_R_21 K_R_22 K_R_23 K_R_24 K_R_25 K_R_26 K_R_27 K_R_28 K_R_29 K_R_30 K_R_31 BLANK_R R_SER_2 R2_IREF 5V TLC5928_FUNC
RI_R2 R2_IREF 0 3.3k
XLED2 A_ROW_0 A_ROW_1 A_ROW_2 A_ROW_3 A_ROW_4 A_ROW_5 A_ROW_6 A_ROW_7 A_ROW_8 A_ROW_9 A_ROW_10 A_ROW_11 A_ROW_12 A_ROW_13 A_ROW_14 A_ROW_15 K_R_16 K_R_17 K_R_18 K_R_19 K_R_20 K_R_21 K_R_22 K_R_23 K_R_24 K_R_25 K_R_26 K_R_27 K_R_28 K_R_29 K_R_30 K_R_31 K_G_16 K_G_17 K_G_18 K_G_19 K_G_20 K_G_21 K_G_22 K_G_23 K_G_24 K_G_25 K_G_26 K_G_27 K_G_28 K_G_29 K_G_30 K_G_31 MATRIX16X16_RG
XR3 0 R_SER_2 SCLK_R LAT_R K_R_32 K_R_33 K_R_34 K_R_35 K_R_36 K_R_37 K_R_38 K_R_39 K_R_40 K_R_41 K_R_42 K_R_43 K_R_44 K_R_45 K_R_46 K_R_47 BLANK_R ROW_SER R3_IREF 5V TLC5928_FUNC
RI_R3 R3_IREF 0 3.3k
XLED3 A_ROW_0 A_ROW_1 A_ROW_2 A_ROW_3 A_ROW_4 A_ROW_5 A_ROW_6 A_ROW_7 A_ROW_8 A_ROW_9 A_ROW_10 A_ROW_11 A_ROW_12 A_ROW_13 A_ROW_14 A_ROW_15 K_R_32 K_R_33 K_R_34 K_R_35 K_R_36 K_R_37 K_R_38 K_R_39 K_R_40 K_R_41 K_R_42 K_R_43 K_R_44 K_R_45 K_R_46 K_R_47 K_G_32 K_G_33 K_G_34 K_G_35 K_G_36 K_G_37 K_G_38 K_G_39 K_G_40 K_G_41 K_G_42 K_G_43 K_G_44 K_G_45 K_G_46 K_G_47 MATRIX16X16_RG
XG1 0 DATA_G SCLK_G LAT_G K_G_0 K_G_1 K_G_2 K_G_3 K_G_4 K_G_5 K_G_6 K_G_7 K_G_8 K_G_9 K_G_10 K_G_11 K_G_12 K_G_13 K_G_14 K_G_15 BLANK_G G_SER_1 G1_IREF 5V TLC5928_FUNC
RI_G1 G1_IREF 0 3.3k
XG2 0 G_SER_1 SCLK_G LAT_G K_G_16 K_G_17 K_G_18 K_G_19 K_G_20 K_G_21 K_G_22 K_G_23 K_G_24 K_G_25 K_G_26 K_G_27 K_G_28 K_G_29 K_G_30 K_G_31 BLANK_G G_SER_2 G2_IREF 5V TLC5928_FUNC
RI_G2 G2_IREF 0 3.3k
XG3 0 G_SER_2 SCLK_G LAT_G K_G_32 K_G_33 K_G_34 K_G_35 K_G_36 K_G_37 K_G_38 K_G_39 K_G_40 K_G_41 K_G_42 K_G_43 K_G_44 K_G_45 K_G_46 K_G_47 BLANK_G NC_G_SOUT G3_IREF 5V TLC5928_FUNC
RI_G3 G3_IREF 0 3.3k
XROW1 ROW_CTL_1 ROW_CTL_2 ROW_CTL_3 ROW_CTL_4 ROW_CTL_5 ROW_CTL_6 ROW_CTL_7 0 ROW_CASCADE 5V SCLK_R LAT_R 0 ROW_SER ROW_CTL_0 5V HC595_FUNC
XULN1 ROW_CTL_0 ROW_CTL_1 ROW_CTL_2 ROW_CTL_3 ROW_CTL_4 ROW_CTL_5 ROW_CTL_6 ROW_CTL_7 0 5V GATE_LOW_7 GATE_LOW_6 GATE_LOW_5 GATE_LOW_4 GATE_LOW_3 GATE_LOW_2 GATE_LOW_1 GATE_LOW_0 ULN2803_FUNC
RG0 GATE_LOW_0 GATE_0 100
MQ0 A_ROW_0 GATE_0 5V_LED PMOS_FULL
CG_EXTRA0 GATE_0 5V 4n
RGS0 5V GATE_0 10k
RG1 GATE_LOW_1 GATE_1 100
MQ1 A_ROW_1 GATE_1 5V_LED PMOS_FULL
CG_EXTRA1 GATE_1 5V 4n
RGS1 5V GATE_1 10k
RG2 GATE_LOW_2 GATE_2 100
MQ2 A_ROW_2 GATE_2 5V_LED PMOS_FULL
CG_EXTRA2 GATE_2 5V 4n
RGS2 5V GATE_2 10k
RG3 GATE_LOW_3 GATE_3 100
MQ3 A_ROW_3 GATE_3 5V_LED PMOS_FULL
CG_EXTRA3 GATE_3 5V 4n
RGS3 5V GATE_3 10k
RG4 GATE_LOW_4 GATE_4 100
MQ4 A_ROW_4 GATE_4 5V_LED PMOS_FULL
CG_EXTRA4 GATE_4 5V 4n
RGS4 5V GATE_4 10k
RG5 GATE_LOW_5 GATE_5 100
MQ5 A_ROW_5 GATE_5 5V_LED PMOS_FULL
CG_EXTRA5 GATE_5 5V 4n
RGS5 5V GATE_5 10k
RG6 GATE_LOW_6 GATE_6 100
MQ6 A_ROW_6 GATE_6 5V_LED PMOS_FULL
CG_EXTRA6 GATE_6 5V 4n
RGS6 5V GATE_6 10k
RG7 GATE_LOW_7 GATE_7 100
MQ7 A_ROW_7 GATE_7 5V_LED PMOS_FULL
CG_EXTRA7 GATE_7 5V 4n
RGS7 5V GATE_7 10k
XROW2 ROW_CTL_9 ROW_CTL_10 ROW_CTL_11 ROW_CTL_12 ROW_CTL_13 ROW_CTL_14 ROW_CTL_15 0 NC_ROW_SOUT 5V SCLK_R LAT_R 0 ROW_CASCADE ROW_CTL_8 5V HC595_FUNC
XULN2 ROW_CTL_8 ROW_CTL_9 ROW_CTL_10 ROW_CTL_11 ROW_CTL_12 ROW_CTL_13 ROW_CTL_14 ROW_CTL_15 0 5V GATE_LOW_15 GATE_LOW_14 GATE_LOW_13 GATE_LOW_12 GATE_LOW_11 GATE_LOW_10 GATE_LOW_9 GATE_LOW_8 ULN2803_FUNC
RG8 GATE_LOW_8 GATE_8 100
MQ8 A_ROW_8 GATE_8 5V_LED PMOS_FULL
CG_EXTRA8 GATE_8 5V 4n
RGS8 5V GATE_8 10k
RG9 GATE_LOW_9 GATE_9 100
MQ9 A_ROW_9 GATE_9 5V_LED PMOS_FULL
CG_EXTRA9 GATE_9 5V 4n
RGS9 5V GATE_9 10k
RG10 GATE_LOW_10 GATE_10 100
MQ10 A_ROW_10 GATE_10 5V_LED PMOS_FULL
CG_EXTRA10 GATE_10 5V 4n
RGS10 5V GATE_10 10k
RG11 GATE_LOW_11 GATE_11 100
MQ11 A_ROW_11 GATE_11 5V_LED PMOS_FULL
CG_EXTRA11 GATE_11 5V 4n
RGS11 5V GATE_11 10k
RG12 GATE_LOW_12 GATE_12 100
MQ12 A_ROW_12 GATE_12 5V_LED PMOS_FULL
CG_EXTRA12 GATE_12 5V 4n
RGS12 5V GATE_12 10k
RG13 GATE_LOW_13 GATE_13 100
MQ13 A_ROW_13 GATE_13 5V_LED PMOS_FULL
CG_EXTRA13 GATE_13 5V 4n
RGS13 5V GATE_13 10k
RG14 GATE_LOW_14 GATE_14 100
MQ14 A_ROW_14 GATE_14 5V_LED PMOS_FULL
CG_EXTRA14 GATE_14 5V 4n
RGS14 5V GATE_14 10k
RG15 GATE_LOW_15 GATE_15 100
MQ15 A_ROW_15 GATE_15 5V_LED PMOS_FULL
CG_EXTRA15 GATE_15 5V 4n
RGS15 5V GATE_15 10k
C_BUF1 5V 0 100n
C_BUF2 5V 0 100n
C_R1 5V 0 100n
C_R2 5V 0 100n
C_R3 5V 0 100n
C_G1 5V 0 100n
C_G2 5V 0 100n
C_G3 5V 0 100n
C_ROW1 5V 0 100n
C_ROW2 5V 0 100n
Cbulk 5V 0 1000u Rser=0.05
R_BLANK_R 5V BLANK_R 10k
R_BLANK_G 5V BLANK_G 10k
VDD V_IN 0 5
RFEED V_IN 5V 0.1
VLED_SENSE 5V 5V_LED 0
.include full_models.lib
.tran 0 16.2m 0 500n
.options plotwinsize=0
.save V(5V) V(BLANK_R) V(LAT_R) V(SCLK_R) V(DATA_R) V(ROW_CTL_0) V(ROW_CTL_1) V(ROW_CTL_2) V(ROW_CTL_3) V(ROW_CTL_4) V(ROW_CTL_5) V(ROW_CTL_6) V(ROW_CTL_7) V(ROW_CTL_8) V(ROW_CTL_9) V(ROW_CTL_10) V(ROW_CTL_11) V(ROW_CTL_12) V(ROW_CTL_13) V(ROW_CTL_14) V(ROW_CTL_15) V(A_ROW_0) V(A_ROW_1) V(GATE_0) V(GATE_1) I(VDD) I(VLED_SENSE)
.meas tran SUPPLY_MIN MIN V(5V) FROM 500u TO 15.8m
.meas tran ROW0_CTL FIND V(ROW_CTL_0) AT=0.5m
.meas tran ROW1_CTL FIND V(ROW_CTL_1) AT=1.5m
.meas tran ROW2_CTL FIND V(ROW_CTL_2) AT=2.5m
.meas tran ROW3_CTL FIND V(ROW_CTL_3) AT=3.5m
.meas tran ROW4_CTL FIND V(ROW_CTL_4) AT=4.5m
.meas tran ROW5_CTL FIND V(ROW_CTL_5) AT=5.5m
.meas tran ROW6_CTL FIND V(ROW_CTL_6) AT=6.5m
.meas tran ROW7_CTL FIND V(ROW_CTL_7) AT=7.5m
.meas tran ROW8_CTL FIND V(ROW_CTL_8) AT=8.5m
.meas tran ROW9_CTL FIND V(ROW_CTL_9) AT=9.5m
.meas tran ROW10_CTL FIND V(ROW_CTL_10) AT=10.5m
.meas tran ROW11_CTL FIND V(ROW_CTL_11) AT=11.5m
.meas tran ROW12_CTL FIND V(ROW_CTL_12) AT=12.5m
.meas tran ROW13_CTL FIND V(ROW_CTL_13) AT=13.5m
.meas tran ROW14_CTL FIND V(ROW_CTL_14) AT=14.5m
.meas tran ROW15_CTL FIND V(ROW_CTL_15) AT=15.5m
.meas tran ROW0_CURRENT FIND I(VLED_SENSE) AT=0.5m
.meas tran ROW1_CURRENT FIND I(VLED_SENSE) AT=1.5m
.meas tran ROW2_CURRENT FIND I(VLED_SENSE) AT=2.5m
.meas tran ROW3_CURRENT FIND I(VLED_SENSE) AT=3.5m
.meas tran ROW4_CURRENT FIND I(VLED_SENSE) AT=4.5m
.meas tran ROW5_CURRENT FIND I(VLED_SENSE) AT=5.5m
.meas tran ROW6_CURRENT FIND I(VLED_SENSE) AT=6.5m
.meas tran ROW7_CURRENT FIND I(VLED_SENSE) AT=7.5m
.meas tran ROW8_CURRENT FIND I(VLED_SENSE) AT=8.5m
.meas tran ROW9_CURRENT FIND I(VLED_SENSE) AT=9.5m
.meas tran ROW10_CURRENT FIND I(VLED_SENSE) AT=10.5m
.meas tran ROW11_CURRENT FIND I(VLED_SENSE) AT=11.5m
.meas tran ROW12_CURRENT FIND I(VLED_SENSE) AT=12.5m
.meas tran ROW13_CURRENT FIND I(VLED_SENSE) AT=13.5m
.meas tran ROW14_CURRENT FIND I(VLED_SENSE) AT=14.5m
.meas tran ROW15_CURRENT FIND I(VLED_SENSE) AT=15.5m
.meas tran ROW0_COUNT FIND (if(V(ROW_CTL_0)>2.5,1,0)+if(V(ROW_CTL_1)>2.5,1,0)+if(V(ROW_CTL_2)>2.5,1,0)+if(V(ROW_CTL_3)>2.5,1,0)+if(V(ROW_CTL_4)>2.5,1,0)+if(V(ROW_CTL_5)>2.5,1,0)+if(V(ROW_CTL_6)>2.5,1,0)+if(V(ROW_CTL_7)>2.5,1,0)+if(V(ROW_CTL_8)>2.5,1,0)+if(V(ROW_CTL_9)>2.5,1,0)+if(V(ROW_CTL_10)>2.5,1,0)+if(V(ROW_CTL_11)>2.5,1,0)+if(V(ROW_CTL_12)>2.5,1,0)+if(V(ROW_CTL_13)>2.5,1,0)+if(V(ROW_CTL_14)>2.5,1,0)+if(V(ROW_CTL_15)>2.5,1,0)) AT=0.5m
.meas tran ROW1_COUNT FIND (if(V(ROW_CTL_0)>2.5,1,0)+if(V(ROW_CTL_1)>2.5,1,0)+if(V(ROW_CTL_2)>2.5,1,0)+if(V(ROW_CTL_3)>2.5,1,0)+if(V(ROW_CTL_4)>2.5,1,0)+if(V(ROW_CTL_5)>2.5,1,0)+if(V(ROW_CTL_6)>2.5,1,0)+if(V(ROW_CTL_7)>2.5,1,0)+if(V(ROW_CTL_8)>2.5,1,0)+if(V(ROW_CTL_9)>2.5,1,0)+if(V(ROW_CTL_10)>2.5,1,0)+if(V(ROW_CTL_11)>2.5,1,0)+if(V(ROW_CTL_12)>2.5,1,0)+if(V(ROW_CTL_13)>2.5,1,0)+if(V(ROW_CTL_14)>2.5,1,0)+if(V(ROW_CTL_15)>2.5,1,0)) AT=1.5m
.meas tran ROW2_COUNT FIND (if(V(ROW_CTL_0)>2.5,1,0)+if(V(ROW_CTL_1)>2.5,1,0)+if(V(ROW_CTL_2)>2.5,1,0)+if(V(ROW_CTL_3)>2.5,1,0)+if(V(ROW_CTL_4)>2.5,1,0)+if(V(ROW_CTL_5)>2.5,1,0)+if(V(ROW_CTL_6)>2.5,1,0)+if(V(ROW_CTL_7)>2.5,1,0)+if(V(ROW_CTL_8)>2.5,1,0)+if(V(ROW_CTL_9)>2.5,1,0)+if(V(ROW_CTL_10)>2.5,1,0)+if(V(ROW_CTL_11)>2.5,1,0)+if(V(ROW_CTL_12)>2.5,1,0)+if(V(ROW_CTL_13)>2.5,1,0)+if(V(ROW_CTL_14)>2.5,1,0)+if(V(ROW_CTL_15)>2.5,1,0)) AT=2.5m
.meas tran ROW3_COUNT FIND (if(V(ROW_CTL_0)>2.5,1,0)+if(V(ROW_CTL_1)>2.5,1,0)+if(V(ROW_CTL_2)>2.5,1,0)+if(V(ROW_CTL_3)>2.5,1,0)+if(V(ROW_CTL_4)>2.5,1,0)+if(V(ROW_CTL_5)>2.5,1,0)+if(V(ROW_CTL_6)>2.5,1,0)+if(V(ROW_CTL_7)>2.5,1,0)+if(V(ROW_CTL_8)>2.5,1,0)+if(V(ROW_CTL_9)>2.5,1,0)+if(V(ROW_CTL_10)>2.5,1,0)+if(V(ROW_CTL_11)>2.5,1,0)+if(V(ROW_CTL_12)>2.5,1,0)+if(V(ROW_CTL_13)>2.5,1,0)+if(V(ROW_CTL_14)>2.5,1,0)+if(V(ROW_CTL_15)>2.5,1,0)) AT=3.5m
.meas tran ROW4_COUNT FIND (if(V(ROW_CTL_0)>2.5,1,0)+if(V(ROW_CTL_1)>2.5,1,0)+if(V(ROW_CTL_2)>2.5,1,0)+if(V(ROW_CTL_3)>2.5,1,0)+if(V(ROW_CTL_4)>2.5,1,0)+if(V(ROW_CTL_5)>2.5,1,0)+if(V(ROW_CTL_6)>2.5,1,0)+if(V(ROW_CTL_7)>2.5,1,0)+if(V(ROW_CTL_8)>2.5,1,0)+if(V(ROW_CTL_9)>2.5,1,0)+if(V(ROW_CTL_10)>2.5,1,0)+if(V(ROW_CTL_11)>2.5,1,0)+if(V(ROW_CTL_12)>2.5,1,0)+if(V(ROW_CTL_13)>2.5,1,0)+if(V(ROW_CTL_14)>2.5,1,0)+if(V(ROW_CTL_15)>2.5,1,0)) AT=4.5m
.meas tran ROW5_COUNT FIND (if(V(ROW_CTL_0)>2.5,1,0)+if(V(ROW_CTL_1)>2.5,1,0)+if(V(ROW_CTL_2)>2.5,1,0)+if(V(ROW_CTL_3)>2.5,1,0)+if(V(ROW_CTL_4)>2.5,1,0)+if(V(ROW_CTL_5)>2.5,1,0)+if(V(ROW_CTL_6)>2.5,1,0)+if(V(ROW_CTL_7)>2.5,1,0)+if(V(ROW_CTL_8)>2.5,1,0)+if(V(ROW_CTL_9)>2.5,1,0)+if(V(ROW_CTL_10)>2.5,1,0)+if(V(ROW_CTL_11)>2.5,1,0)+if(V(ROW_CTL_12)>2.5,1,0)+if(V(ROW_CTL_13)>2.5,1,0)+if(V(ROW_CTL_14)>2.5,1,0)+if(V(ROW_CTL_15)>2.5,1,0)) AT=5.5m
.meas tran ROW6_COUNT FIND (if(V(ROW_CTL_0)>2.5,1,0)+if(V(ROW_CTL_1)>2.5,1,0)+if(V(ROW_CTL_2)>2.5,1,0)+if(V(ROW_CTL_3)>2.5,1,0)+if(V(ROW_CTL_4)>2.5,1,0)+if(V(ROW_CTL_5)>2.5,1,0)+if(V(ROW_CTL_6)>2.5,1,0)+if(V(ROW_CTL_7)>2.5,1,0)+if(V(ROW_CTL_8)>2.5,1,0)+if(V(ROW_CTL_9)>2.5,1,0)+if(V(ROW_CTL_10)>2.5,1,0)+if(V(ROW_CTL_11)>2.5,1,0)+if(V(ROW_CTL_12)>2.5,1,0)+if(V(ROW_CTL_13)>2.5,1,0)+if(V(ROW_CTL_14)>2.5,1,0)+if(V(ROW_CTL_15)>2.5,1,0)) AT=6.5m
.meas tran ROW7_COUNT FIND (if(V(ROW_CTL_0)>2.5,1,0)+if(V(ROW_CTL_1)>2.5,1,0)+if(V(ROW_CTL_2)>2.5,1,0)+if(V(ROW_CTL_3)>2.5,1,0)+if(V(ROW_CTL_4)>2.5,1,0)+if(V(ROW_CTL_5)>2.5,1,0)+if(V(ROW_CTL_6)>2.5,1,0)+if(V(ROW_CTL_7)>2.5,1,0)+if(V(ROW_CTL_8)>2.5,1,0)+if(V(ROW_CTL_9)>2.5,1,0)+if(V(ROW_CTL_10)>2.5,1,0)+if(V(ROW_CTL_11)>2.5,1,0)+if(V(ROW_CTL_12)>2.5,1,0)+if(V(ROW_CTL_13)>2.5,1,0)+if(V(ROW_CTL_14)>2.5,1,0)+if(V(ROW_CTL_15)>2.5,1,0)) AT=7.5m
.meas tran ROW8_COUNT FIND (if(V(ROW_CTL_0)>2.5,1,0)+if(V(ROW_CTL_1)>2.5,1,0)+if(V(ROW_CTL_2)>2.5,1,0)+if(V(ROW_CTL_3)>2.5,1,0)+if(V(ROW_CTL_4)>2.5,1,0)+if(V(ROW_CTL_5)>2.5,1,0)+if(V(ROW_CTL_6)>2.5,1,0)+if(V(ROW_CTL_7)>2.5,1,0)+if(V(ROW_CTL_8)>2.5,1,0)+if(V(ROW_CTL_9)>2.5,1,0)+if(V(ROW_CTL_10)>2.5,1,0)+if(V(ROW_CTL_11)>2.5,1,0)+if(V(ROW_CTL_12)>2.5,1,0)+if(V(ROW_CTL_13)>2.5,1,0)+if(V(ROW_CTL_14)>2.5,1,0)+if(V(ROW_CTL_15)>2.5,1,0)) AT=8.5m
.meas tran ROW9_COUNT FIND (if(V(ROW_CTL_0)>2.5,1,0)+if(V(ROW_CTL_1)>2.5,1,0)+if(V(ROW_CTL_2)>2.5,1,0)+if(V(ROW_CTL_3)>2.5,1,0)+if(V(ROW_CTL_4)>2.5,1,0)+if(V(ROW_CTL_5)>2.5,1,0)+if(V(ROW_CTL_6)>2.5,1,0)+if(V(ROW_CTL_7)>2.5,1,0)+if(V(ROW_CTL_8)>2.5,1,0)+if(V(ROW_CTL_9)>2.5,1,0)+if(V(ROW_CTL_10)>2.5,1,0)+if(V(ROW_CTL_11)>2.5,1,0)+if(V(ROW_CTL_12)>2.5,1,0)+if(V(ROW_CTL_13)>2.5,1,0)+if(V(ROW_CTL_14)>2.5,1,0)+if(V(ROW_CTL_15)>2.5,1,0)) AT=9.5m
.meas tran ROW10_COUNT FIND (if(V(ROW_CTL_0)>2.5,1,0)+if(V(ROW_CTL_1)>2.5,1,0)+if(V(ROW_CTL_2)>2.5,1,0)+if(V(ROW_CTL_3)>2.5,1,0)+if(V(ROW_CTL_4)>2.5,1,0)+if(V(ROW_CTL_5)>2.5,1,0)+if(V(ROW_CTL_6)>2.5,1,0)+if(V(ROW_CTL_7)>2.5,1,0)+if(V(ROW_CTL_8)>2.5,1,0)+if(V(ROW_CTL_9)>2.5,1,0)+if(V(ROW_CTL_10)>2.5,1,0)+if(V(ROW_CTL_11)>2.5,1,0)+if(V(ROW_CTL_12)>2.5,1,0)+if(V(ROW_CTL_13)>2.5,1,0)+if(V(ROW_CTL_14)>2.5,1,0)+if(V(ROW_CTL_15)>2.5,1,0)) AT=10.5m
.meas tran ROW11_COUNT FIND (if(V(ROW_CTL_0)>2.5,1,0)+if(V(ROW_CTL_1)>2.5,1,0)+if(V(ROW_CTL_2)>2.5,1,0)+if(V(ROW_CTL_3)>2.5,1,0)+if(V(ROW_CTL_4)>2.5,1,0)+if(V(ROW_CTL_5)>2.5,1,0)+if(V(ROW_CTL_6)>2.5,1,0)+if(V(ROW_CTL_7)>2.5,1,0)+if(V(ROW_CTL_8)>2.5,1,0)+if(V(ROW_CTL_9)>2.5,1,0)+if(V(ROW_CTL_10)>2.5,1,0)+if(V(ROW_CTL_11)>2.5,1,0)+if(V(ROW_CTL_12)>2.5,1,0)+if(V(ROW_CTL_13)>2.5,1,0)+if(V(ROW_CTL_14)>2.5,1,0)+if(V(ROW_CTL_15)>2.5,1,0)) AT=11.5m
.meas tran ROW12_COUNT FIND (if(V(ROW_CTL_0)>2.5,1,0)+if(V(ROW_CTL_1)>2.5,1,0)+if(V(ROW_CTL_2)>2.5,1,0)+if(V(ROW_CTL_3)>2.5,1,0)+if(V(ROW_CTL_4)>2.5,1,0)+if(V(ROW_CTL_5)>2.5,1,0)+if(V(ROW_CTL_6)>2.5,1,0)+if(V(ROW_CTL_7)>2.5,1,0)+if(V(ROW_CTL_8)>2.5,1,0)+if(V(ROW_CTL_9)>2.5,1,0)+if(V(ROW_CTL_10)>2.5,1,0)+if(V(ROW_CTL_11)>2.5,1,0)+if(V(ROW_CTL_12)>2.5,1,0)+if(V(ROW_CTL_13)>2.5,1,0)+if(V(ROW_CTL_14)>2.5,1,0)+if(V(ROW_CTL_15)>2.5,1,0)) AT=12.5m
.meas tran ROW13_COUNT FIND (if(V(ROW_CTL_0)>2.5,1,0)+if(V(ROW_CTL_1)>2.5,1,0)+if(V(ROW_CTL_2)>2.5,1,0)+if(V(ROW_CTL_3)>2.5,1,0)+if(V(ROW_CTL_4)>2.5,1,0)+if(V(ROW_CTL_5)>2.5,1,0)+if(V(ROW_CTL_6)>2.5,1,0)+if(V(ROW_CTL_7)>2.5,1,0)+if(V(ROW_CTL_8)>2.5,1,0)+if(V(ROW_CTL_9)>2.5,1,0)+if(V(ROW_CTL_10)>2.5,1,0)+if(V(ROW_CTL_11)>2.5,1,0)+if(V(ROW_CTL_12)>2.5,1,0)+if(V(ROW_CTL_13)>2.5,1,0)+if(V(ROW_CTL_14)>2.5,1,0)+if(V(ROW_CTL_15)>2.5,1,0)) AT=13.5m
.meas tran ROW14_COUNT FIND (if(V(ROW_CTL_0)>2.5,1,0)+if(V(ROW_CTL_1)>2.5,1,0)+if(V(ROW_CTL_2)>2.5,1,0)+if(V(ROW_CTL_3)>2.5,1,0)+if(V(ROW_CTL_4)>2.5,1,0)+if(V(ROW_CTL_5)>2.5,1,0)+if(V(ROW_CTL_6)>2.5,1,0)+if(V(ROW_CTL_7)>2.5,1,0)+if(V(ROW_CTL_8)>2.5,1,0)+if(V(ROW_CTL_9)>2.5,1,0)+if(V(ROW_CTL_10)>2.5,1,0)+if(V(ROW_CTL_11)>2.5,1,0)+if(V(ROW_CTL_12)>2.5,1,0)+if(V(ROW_CTL_13)>2.5,1,0)+if(V(ROW_CTL_14)>2.5,1,0)+if(V(ROW_CTL_15)>2.5,1,0)) AT=14.5m
.meas tran ROW15_COUNT FIND (if(V(ROW_CTL_0)>2.5,1,0)+if(V(ROW_CTL_1)>2.5,1,0)+if(V(ROW_CTL_2)>2.5,1,0)+if(V(ROW_CTL_3)>2.5,1,0)+if(V(ROW_CTL_4)>2.5,1,0)+if(V(ROW_CTL_5)>2.5,1,0)+if(V(ROW_CTL_6)>2.5,1,0)+if(V(ROW_CTL_7)>2.5,1,0)+if(V(ROW_CTL_8)>2.5,1,0)+if(V(ROW_CTL_9)>2.5,1,0)+if(V(ROW_CTL_10)>2.5,1,0)+if(V(ROW_CTL_11)>2.5,1,0)+if(V(ROW_CTL_12)>2.5,1,0)+if(V(ROW_CTL_13)>2.5,1,0)+if(V(ROW_CTL_14)>2.5,1,0)+if(V(ROW_CTL_15)>2.5,1,0)) AT=15.5m
.end
