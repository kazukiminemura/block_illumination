Adjacent-row electrical test, 48 columns/color, behavioral TLC output
VDD VIN 0 5
RWIRE VIN V5 0.1
CBULK V5 0 1000u Rser=0.05
VULNLOW ULN_LOW 0 0.8
VROW0 CTL0 0 PWL(0 5 999.99u 5 1m 0)
VROW1 CTL1 0 PWL(0 0 1m 0 1.00001m 5)
VBLANK BLANK 0 PWL(0 5 124.99u 5 125u 0 999.99u 0 1m 5 {1m+TGUARD} 5 {1m+TGUARD+10n} 0)
SULN0 ULN0 ULN_LOW CTL0 0 ULN_EQ
RG0 ULN0 GATE0 100
RGS0 V5 GATE0 10k
CG0 GATE0 V5 {CGATE}
MROW0 DRAIN0 GATE0 V5 PMOS_ASSUMED
VSENSE0 DRAIN0 ANODE0 0
RBLEED0 ANODE0 0 1Meg
D0R ANODE0 KR LED_RED 48
D0G ANODE0 KG LED_GREEN 48
SULN1 ULN1 ULN_LOW CTL1 0 ULN_EQ
RG1 ULN1 GATE1 100
RGS1 V5 GATE1 10k
CG1 GATE1 V5 {CGATE}
MROW1 DRAIN1 GATE1 V5 PMOS_ASSUMED
VSENSE1 DRAIN1 ANODE1 0
RBLEED1 ANODE1 0 1Meg
D1R ANODE1 KR LED_RED 48
D1G ANODE1 KG LED_GREEN 48
BRED KR 0 I=if(V(BLANK)<2.5,48*ILED*limit(V(KR)/0.4,0,1),0)
BGREEN KG 0 I=if(V(BLANK)<2.5,48*ILED*limit(V(KG)/0.4,0,1),0)
.param ILED=1.2*42/10000
.step param TGUARD list 10u 100u
.step param CGATE list 1n 4n
* Explicit assumption models, NOT vendor AO3401A / ULN / TLC macro models.
.model PMOS_ASSUMED VDMOS(pchan Vto=-1 Kp=20 Rd=0.025 Rs=0.025 Cgs=1n Cgdmax=300p Cgdmin=50p Cjo=100p Is=1n)
.model ULN_EQ SW(Ron=20 Roff=1G Vt=2.5 Vh=-0.1)
.model LED_RED D(Is=1e-18 N=2 Rs=2 Cjo=10p)
.model LED_GREEN D(Is=1e-23 N=2 Rs=3 Cjo=10p)
.tran 0 1.6m 0 100n
.options plotwinsize=0
.save V(V5) V(DRAIN0) V(GATE0) V(GATE1) V(ANODE0) V(ANODE1) V(BLANK) V(CTL0) V(CTL1) I(VSENSE0) I(VSENSE1) I(D0R) I(D0G) I(D1R) I(D1G) I(VDD) V(KR) V(KG)
.meas tran LED_PEAK MAX (I(VSENSE0)+I(VSENSE1)) FROM 400u TO 800u
.meas tran LED_STEADY AVG (I(VSENSE0)+I(VSENSE1)) FROM 400u TO 800u
.meas tran BLANK_LEAK MAX (I(D0R)+I(D0G)+I(D1R)+I(D1G)) FROM 1.0001m TO {1m+TGUARD-0.1u}
.meas tran GHOST_OLD MAX (I(D0R)+I(D0G)) FROM {1m+TGUARD+2u} TO 1.4m
.meas tran NEW_ROW AVG I(VSENSE1) FROM 1.4m TO 1.5m
.meas tran RAIL_MIN MIN V(V5) FROM 125u TO 1.5m
.meas tran PMOS0_DROP AVG V(V5,DRAIN0) FROM 400u TO 800u
.meas tran PMOS0_POWER AVG (V(V5,DRAIN0)*I(VSENSE0)) FROM 400u TO 800u
.meas tran GHOST_CHARGE INTEG (I(D0R)+I(D0G)) FROM {1m+TGUARD+2u} TO 1.4m
.meas tran SINK_RED_POWER AVG (V(KR)*(I(D0R)+I(D1R))) FROM 400u TO 800u
.end
